.title KiCad schematic
C123 GND /+5VA 100n
C120 Net-_U105-P0A_ Net-_U105-P0B_ 100n
C119 Net-_U105-P0A_ Net-_U105-P0B_ 100n
U105 __U105
R123 Net-_C117-Pad1_ Net-_U106-P0A_ 3.3k
C122 Net-_U106-P0A_ Net-_U106-P0B_ 100n
R117 GND Net-_U103B-+_ 22k
C121 Net-_U106-P0A_ Net-_U106-P0B_ 100n
U106 __U106
J102 __J102
C124 GND /+5VA 100n
R120 Net-_U101B--_ Net-_U105-P0W_ 10k
R119 Net-_C115-Pad1_ Net-_U105-P0A_ 3.3k
R121 Net-_C111-Pad2_ Net-_U105-P0B_ 3.3k
C111 Net-_C111-Pad2_ Net-_U101B--_ 22p
R122 Net-_U101B--_ Net-_U105-P1W_ 10k
C115 Net-_U105-P1A_ Net-_C115-Pad1_ 10n
C116 Net-_U105-P1B_ Net-_C111-Pad2_ 10n
U101 __U101
C112 Net-_C111-Pad2_ Net-_U103B-+_ 1.5u
U102 __U102
C113 Net-_C113-Pad2_ Net-_U102B--_ 22p
C114 Net-_C113-Pad2_ Net-_U103A-+_ 1.5u
C118 Net-_U106-P1B_ Net-_C113-Pad2_ 100n
R126 Net-_U102B--_ Net-_U106-P1W_ 10k
R125 Net-_C113-Pad2_ Net-_U106-P0B_ 3.3k
R124 Net-_U102B--_ Net-_U106-P0W_ 10k
C117 Net-_U106-P1A_ Net-_C117-Pad1_ 100n
C106 GND /-5VA 100n
C108 GND /-5VA 100n
C102 GND /-5VA 100n
J103 __J103
C127 GND /+5VA 10u
C103 GND /+5VA 100n
C104 GND Net-_U104-+_ 10u
R101 /+5VA Net-_U104-+_ 10k
R102 Net-_U104-+_ GND 10k
U104 __U104
R113 Net-_U101A--_ Net-_C115-Pad1_ 10k
R115 Net-_U103B--_ GND 5k
R111 Net-_R107-Pad2_ Net-_U103B--_ 10k
U103 __U103
C125 Net-_C115-Pad1_ Net-_U101A--_ 22p
R114 Net-_U102A--_ Net-_C117-Pad1_ 10k
C126 Net-_C117-Pad1_ Net-_U102A--_ 22p
R110 Net-_R105-Pad2_ Net-_U102A--_ 10k
R106 /+2.5V Net-_R105-Pad2_ 10k
R105 Net-_J101-Pin_9_ Net-_R105-Pad2_ 10k
R107 Net-_J101-Pin_5_ Net-_R107-Pad2_ 100
R109 Net-_R103-Pad2_ Net-_U101A--_ 10k
R103 Net-_J101-Pin_6_ Net-_R103-Pad2_ 10k
R104 /+2.5V Net-_R103-Pad2_ 10k
R112 Net-_R108-Pad2_ Net-_U103A--_ 10k
R118 GND Net-_U103A-+_ 22k
R116 Net-_U103A--_ GND 5k
R108 Net-_J101-Pin_8_ Net-_R108-Pad2_ 100
C107 GND /+5VA 100n
C101 GND /+5VA 100n
C105 GND /+5VA 100n
C110 GND /+5VA 10u
C109 GND /+5VA 10u
J101 __J101
.end
